ADE simulation setup
Run mode: Single Run, Sweeps and Corners
Tests:
  KoggeStone_ALU_Kogge_1: KoggeStone_ALU/Kogge/schematic, simulator spectre
    Outputs: /A0; /B0; /Cin; "/G0a"; /G0a; /G0b; "/G0c"; /A1; /A2; /A3; /B1; /B2; "/B3"; /B3; "/P00"; /P00; /P01; /P02; /P03; /G00; /G01; /G02; /G03
