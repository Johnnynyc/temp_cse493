ADE simulation setup
Run mode: Single Run, Sweeps and Corners
Tests:
  lab1_XOR_1: lab1/XOR/schematic, simulator spectre
    Outputs: /A; /B; "/vout"; /vout
