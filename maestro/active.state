ADE simulation setup
Test lab1_XOR_1: lab1/XOR/schematic, simulator spectre
  Models: /util-cse/cadence/local/gpdk045_v_6_0/gpdk045/../models/spectre/gpdk045.scs[mc]
  Temperature: 27
  Stimulus vdd!: voltage dc dc=1 srcType=dc
  Stimulus A: voltage pulse val0=0 val1=1 period=2n width=1n srcType=pulse
  Stimulus B: voltage pulse val0=0 val1=1 period=3n width=1n srcType=pulse
  Analysis tran: stop=8n
  Signals: /A, /B, /vout
Run mode: Single Run, Sweeps and Corners
